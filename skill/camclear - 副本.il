axlCmdRegister( "camClear" 'camclear  ?cmdType "general")
defun( camclear ()
p = axlDMOpenFile("TEMP" "./temp.bat" "w")
fprintf(p "del /f /s /q \".\\*.art\"\n")
fprintf(p "del /f /s /q \".\\*.log\"\n")
fprintf(p "del /f /s /q \".\\*.tag\"\n")
fprintf(p "del /f /s /q \".\\*.drl\"\n")
;fprintf(p "del /f /s /q \".\\*.dxf\"\n")
fprintf(p "del /f /s /q \".\\*.ipc\"\n")
fprintf(p "del /f /s /q \".\\*.jrl,1\"\n")
fprintf(p "del /f /s /q \".\\art_aper.txt\"\n")
fprintf(p "del /f /s /q \".\\art_param.txt\"\n")
fprintf(p "del /f /s /q \".\\nc_param.txt\"\n")
fprintf(p "del /f /s /q \".\\*,1\"\n")
fprintf(p "rd /s /q signoise.run\n")
fprintf(p "echo\n")
axlDMClose(p)
axlShell("system temp.bat")
printf("\n###On current directory *.log *.drl  *.tag *.ipc *.art *.jrl,1 \n")
printf("###nc_param.txt art_param.txt art_aper.txt signoise.run \n###CLEAR is finished ====\n")
printf("\n## \265\261\307\260\304\277\302\274\317\302\265\304Gerber\316\304\274\376\322\321\307\345\263\375!! ##\n")
);end-defun camclear
